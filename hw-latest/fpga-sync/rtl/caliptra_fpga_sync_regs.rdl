
addrmap caliptra_fpga_sync_regs {
    default regwidth = 64;
    default accesswidth = 64;

    reg {
        default sw=rw;
        default hw=r;

        field {} pdata[32] = 32'b0;
        field {} paddr[32] = 32'b0;
    } apb_in0;

    reg {
        default sw=rw;
        default hw=r;

        field {} psel = 1'b0;
        field {} penable = 1'b0;
        field {} pwrite = 1'b0;
        field {} pprot[3] = 3'b0;
        field {} pauser[63:32] = 32'b0;
    } apb_in1;

    reg {
        default sw=r;
        default hw=rw;

        field {} pdata[32] = 32'b0;
        field {} pready = 1'b0;
        field {} pslverr = 1'b0;
    } apb_out;

    reg {
        default sw=rw;
        default hw=r;

        field { sw=rw; hw=r; } tck = 1'b0;
        field { sw=rw; hw=r; } tms = 1'b0;
        field { sw=rw; hw=r; } tdi = 1'b0;
        field { sw=rw; hw=r; } trst_n = 1'b0;
    } jtag_in;

    reg {
        default sw=r;
        default hw=rw;

        field {} tdo = 1'b0;
    } jtag_out;

    reg {
        field { sw=rw; hw=r; } value[64] = 64'b0;
    } generic_input_wires;

    reg {
        field { sw=r; hw=rw; } value[64] = 64'b0;
    } generic_output_wires;

    reg {
        default sw=rw;
        default hw=r;

        field {} value[64] = 64'b0;
    } cptra_obf_key[4];

    reg {
        field { sw=rw; hw=r; } cptra_pwrgood = 1'b0;
        field { sw=rw; hw=r; } cptra_rst_b = 1'b0;

        field { sw=rw; hw=r; } ss_debug_locked;
        field { sw=rw; hw=r; } ss_device_lifecycle[2];
        field { sw=rw; hw=r; } scan_mode = 1'b0;

        field { sw=rw; hw=r; } bootfsm_brkpoint = 1'b0;
    } control;

    reg {
        field { sw=r; hw=rw; } cptra_error_fatal = 1'b0;
        field { sw=r; hw=rw; } cptra_error_non_fatal = 1'b0;

        field { sw=r; hw=rw; } ready_for_fuses = 1'b0;
        field { sw=r; hw=rw; } ready_for_fw_push = 1'b0;
        field { sw=r; hw=rw; } ready_for_runtime = 1'b0;

        field { sw=r; hw=rw; } mailbox_data_avail = 1'b0;
        field { sw=r; hw=rw; } mailbox_flow_done = 1'b0;
    } status;

    reg {
        field { sw=rw; hw=r; } itrng_data[4] = 4'b0;
        field { sw=rw; hw=r; } itrng_valid = 1'b0;
    } trng_in;

    reg {
        field { sw=r; hw=rw; } etrng_req = 1'b0;
    } trng_out;

    reg {
        field { sw=rw; hw=rw; } cycle_count[31:0] = 32'b0;
        // Set one to start running until cycle_count hits 0
        field { sw=rw; hw=rw; onwrite=woset; } go[32:32] = 1'b0;
        field { sw=rw; hw=r; hwset; onwrite=woclr; } bkpt_generic_output_wires = 1'b0;
        field { sw=rw; hw=r; hwset; onwrite=woclr; } bkpt_mailbox_data_avail = 1'b0;
        field { sw=rw; hw=r; hwset; onwrite=woclr; } bkpt_mailbox_flow_done = 1'b0;
        field { sw=rw; hw=r; hwset; onwrite=woclr; } bkpt_etrng_req = 1'b0;
    } clock_control;

    reg {
        field { sw=r; hw=rw;} counter[64] = 64'b0;
    } counter;

    mem {
        mementries = 6144;
        memwidth = 64;
    } external rom_mem @ 0x10000;
};